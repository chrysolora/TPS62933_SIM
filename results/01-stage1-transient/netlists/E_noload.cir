* E_E_noload Iload=0.02
.include /mnt/raid10/sim-work/tps62933/TPS62933P_PSPICE_TRANS/TPS62933P_TRANS.lib
X1 BST EN FB GND PG RT SW VIN TPS62933P_TRANS PARAMS: STEADY_STATE=1
Vin 24VIN 0 24
Cf1 24VIN 0 20u ic=24
Lf 24VIN VIN 1u
Cf2 VIN 0 10u ic=24
Cf3 VIN 0 100n ic=24
Ren 24VIN EN 100k
Rpg VIN PG 100k
Rrt RT 0 26.7k
C51 BST SW 100n
Rtop VOUT FB 140k
Rbot FB 0 10k
C18 VOUT FB 2.7p
L2 SW nz 15u ic=0.02
Rl2 nz VOUT 30m
C1 VOUT 0 47u ic=12
Iload VOUT 0 DC 0.02
.options reltol=1e-3 abstol=1e-7 vntol=1e-4 gmin=1e-9 trtol=7 maxstep=2n
.control
run
wrdata /mnt/raid10/sim-work/tps62933/results_v2/E_noload.txt v(vout) v(sw) i(vin) i(l2) v(fb) v(vin)
.endc
.ic V(VOUT)=12 V(FB)=0.8
.tran 2n 80u uic
.end
